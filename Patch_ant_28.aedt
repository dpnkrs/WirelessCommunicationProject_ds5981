# Ansys Electronics Desktop project, version 2016.2
materials:
  vacuum: permittivity=1
  Rogers RO4350 (tm): permittivity=3.66 dielectric_loss_tangent=0.004

design HFSSDesign1 (HFSS, DrivenTerminal, model units mm)
variables:
  substrate = 10mm
  h = 0.15748mm
  Lp = 2.72mm
  Wp = 3.51mm
  x0 = 0.9894mm
  y0 = 0.6mm
  w50 = 0.3mm
  L1 = 1mm
  QW = 6mm
geometry:
  Substrate [Rogers RO4350 (tm)] = box(corner=(-substrate/2, -substrate/2, 0mm), size=(substrate, substrate, -h))
  Ground_Plane = rectangle(corner=(-substrate/2, -substrate/2, -h), x_size=substrate, y_size=substrate)
  Patch = rectangle(corner=(-Lp/2, -Wp/2, 0mm), x_size=Lp, y_size=Wp)
  Gap = rectangle(corner=(Lp/2-x0, -y0/2, 0mm), x_size=x0, y_size=y0)
  Patch.subtract(Gap)
  Feedline = rectangle(corner=(Lp/2-x0, -w50/2, 0mm), x_size=x0+L1, y_size=w50)
  Feedline.unite(Patch)
  Source = object_from(Feedline.edge(x opposite corner))
  Source.sweep_along_vector((0mm, 0mm, -h))
  Air [vacuum] = box(corner=(-substrate/2, -substrate/2, 0mm), size=(substrate, substrate, QW))
boundaries and excitations:
  PerfE_ground: Perfect E Objects=Ground_Plane
  PerfE_Patch: Perfect E Objects=Feedline
  Radiation: Radiation Faces=Air.face(+z, -y, -x, +y, +x)
  1: Terminal port=P1 Edges=Feedline.edge(x opposite corner) TerminalResistance=50ohm
  P1: Lumped Port Faces=Source.face FullResistance=50ohm FullReactance=0ohm
  reference conductors: Ground_Plane
setups:
  Setup1: HfssDriven Frequency=28GHz MaxDeltaS=0.02 MaximumPasses=20 MinimumPasses=1 MinimumConvergedPasses=1 PercentRefinement=30 BasisOrder=1 PortAccuracy=2
    sweep Sweep: 25GHz to 35GHz step 0.1GHz; Type=Discrete SaveFields
source amplitudes:
  P1:1: 1V 0deg
radiation setups:
  Infinite Sphere1: Infinite Sphere Theta=0deg..180deg step 2deg Phi=0deg..360deg step 2deg
field plots:
  Mag_E1, Vector_E1, ComplexMag_E1: E Field over Feedline.face(at (1.3653, 0, 0)) on Setup1 : LastAdaptive at Freq=28GHz Phase=0deg
reports:
  XY Plot 1: dB(St(1,1)) vs Freq on Setup1 : Sweep [substrate=all Lp=all Wp=all]; markers m1 at 28GHz
  3D Polar Plot 1: rETotal vs Phi, Theta on Setup1 : Sweep, Infinite Sphere1 [Freq=28GHz x0=0.9894mm]
  3D Polar Plot 2: dB(GainTotal) vs Phi, Theta on Setup1 : Sweep, Infinite Sphere1 [Freq=28GHz x0=0.9894mm]
